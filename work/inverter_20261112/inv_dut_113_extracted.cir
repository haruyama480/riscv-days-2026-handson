* Extracted by KLayout with GF180MCU LVS runset on : 11/11/2026 11:41

* cell inv_dut_113
* pin A
* pin Q
* pin VDD
* pin VSS
.SUBCKT inv_dut_113 A Q VDD VSS
* device instance $1 r180 *1 -0.6,7.845 pfet_03v3
M$1 VDD A Q VDD pfet_03v3 L=0.3U W=1.8U AS=1.17P AD=1.17P PS=4.9U PD=4.9U
* device instance $2 m90 *1 -0.54,-1.055 nfet_03v3
M$2 VSS A Q VSS nfet_03v3 L=0.3U W=1.8U AS=1.098P AD=1.098P PS=4.82U PD=4.82U
.ENDS inv_dut_113
